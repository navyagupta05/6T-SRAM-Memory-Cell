* C:\Users\user\OneDrive\Documents\LTspiceXVII\SRAM Cell.asc
* Generated by LTspice 26.0.1 for Windows.
C1 Bit 0 80f
V§PC PC 0 PULSE(1.8 0 3n 100p 100p 1n 10n)
V1 VDD 0 1.8
V§D1 D 0 PULSE(0 1.8 0 100p 100p 10n 20n)
V§Write Write 0 PULSE(0 1.8 1n 100p 100p 2n 10n)
C2 Bit_bar 0 100f
V§D_bar1 D_bar 0 PULSE(1.8 0 0 2p 2p 10n 20n)
V§Word Word 0 PULSE(0 1.8 1n 100p 100p 2n 5n)
V§Read Read 0 PULSE(0 1.8 6n 100p 100p 1n 10n)
M1 VDD Q Q_bar N001 CMOSP l=180n w=325n
M2 VDD Q_bar Q N002 CMOSP l=180n w=325n
M3 VDD PC Bit N006 CMOSP l=180n w=800n
M4 VDD PC Bit_bar N005 CMOSP l=180n w=800n
M5 Q_bar Q 0 N004 CMOSN l=180n w=1000n
M6 Q Q_bar 0 N003 CMOSN l=180n w=1000n
M7 Bit Write D 0 CMOSN l=180n w=400n
M8 Bit_bar Write D_bar 0 CMOSN l=180n w=400n
M9 Q Word Bit 0 CMOSN l=180n w=500n
M10 Bit_bar Word Q_bar 0 CMOSN l=180n w=500n
M11 N008 Bit Bit_bar VDD CMOSP l=180n w=400n
M12 N008 Bit_bar Bit VDD CMOSP l=180n w=400n
M13 Bit_bar Bit N009 0 CMOSN l=180n w=800n
M14 Bit Bit_bar N009 0 CMOSN l=180n w=800n
M15 VDD SE_bar N008 N007 CMOSP l=180n w=400n
M16 N009 SE 0 N010 CMOSN l=180n w=800n
V2 SE 0 PULSE(0 1.8 6n 100p 100p 2n 10n)
V3 SE_bar 0 PULSE(1.8 0 6n 100p 100p 2n 10n)
.model NMOS NMOS
.model PMOS PMOS
.lib C:\Users\user\AppData\Local\LTspice\lib\cmp\standard.mos
.INCLUDE tsmc018.lib
.measure Pavg AVG V(VDD)*I(V1)
.tran 80n
.measure t_write TRIG V(Word) VAL=0.9 RISE=1 TARG V(Q) VAL=0.9 FALL=1
.measure t_read TRIG V(Word) VAL=0.9 RISE=1 TARG V(Bit) VAL=0.9 RISE=1
.backanno
.end
